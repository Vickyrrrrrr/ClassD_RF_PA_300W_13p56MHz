// Test measurement syntax in Spectre 14.1
simulator lang=spectre

V1 (vout 0) vsource type=pulse val0=0 val1=5 period=1u rise=10n fall=10n width=0.4u delay=0
R1 (vout 0) resistor r=50

tran tran stop=3u

// Try various syntaxes
meas tran test1 avg vout from=1u to=3u

save vout
